# Ansys Electronics Desktop project, version 2025.2
project variables:
  $R1 = 10mm
  $R2 = 12mm
  $Rs = 12.5mm
  $Wp = 15mm
  $y1 = sqrt($R1*$R1 - ($Wp/2)*($Wp/2))
  $y2 = sqrt($R2*$R2 - ($Wp/2)*($Wp/2))
materials:
  vacuum: permittivity=1
  M19_24G: permeability=2500 conductivity=1960000 core_loss_type="Electrical Steel" core_loss_kh=164.2 core_loss_kc=1.3 core_loss_ke=1.72 mass_density=7650
  copper: permeability=0.999991 conductivity=58000000
  M19_24G - nonlineer: permeability{HUnit=A_per_meter BUnit=tesla curve (0, 0) (22.28, 0.05) (25.46, 0.1) (31.83, 0.15) (47.74, 0.36) (63.66, 0.54) (79.57, 0.65) (159.15, 0.99) (318.3, 1.2) (477.46, 1.28) (636.61, 1.33) (795.77, 1.36) (1591.5, 1.44) (3183, 1.52) (4774.6, 1.58) (6366.1, 1.63) (7957.7, 1.67) (15915, 1.8) (31830, 1.9) (111407, 2) (190984, 2.1) (350138, 2.3) (509292, 2.5)} conductivity=1960000 core_loss_type="Electrical Steel" core_loss_kh=164.2 core_loss_kc=1.3 core_loss_ke=1.72 mass_density=7650

design Maxwell3DDesign1 (Maxwell 3D, Magnetostatic, model units mm)
variables:
  angle = 0deg
geometry:
  Rotor [M19_24G - nonlineer] = circle(normal=Z, centre=(0mm, 0mm, 0mm), radius=12mm)
  Rectangle2 = rectangle(corner=(7.507mm, 9.367mm, 0mm), x_size=6.093mm, y_size=-18.767mm)
  Rotor.subtract(Rectangle2)
  Rectangle3 = rectangle(corner=(-7.5mm, 9.367mm, 0mm), x_size=-5mm, y_size=-50mm)
  Rotor.subtract(Rectangle3)
  Circle1 = circle(normal=Z, centre=(0mm, 0mm, 0mm), radius=10mm)
  Rotor.unite(Circle1)
  Rotor.move(1.9992392mm, 0mm, 0mm)
  Rotor.move(0.5mm, 0mm, 0mm)
  Rotor.move(22.5mm, -15mm, 0mm)
  Rotor.move(-24mm, 14mm, 0mm)
  Rotor.move(-23mm, 0mm, 0mm)
  Rotor.move(22mm, 1mm, 0mm)
  Rotor.move(0mm, -5mm, 0mm)
  Rotor.move(25mm, 5mm, 0mm)
  Rotor.move(-3mm, 0mm, 0mm)
  Rotor.move(30mm, -2mm, 0mm)
  Rotor.move(0.5mm, 0mm, 0mm)
  Rotor.move(0mm, 4mm, 0mm)
  Rotor.move(0mm, -2mm, 0mm)
  Rotor.move(0mm, 2mm, 0mm)
  Rotor.move(0mm, 35mm, 0mm)
  coordinate_system RelativeCS1 = origin=(52.5mm, 37mm, 0mm) x=(1mm, 0mm, 0mm) y=(0mm, 1mm, 0mm)
  Rotor.rotate(axis=Z, angle=135deg) in RelativeCS1
  Rotor.rotate(axis=Z, angle=45deg) in RelativeCS1
  Rotor.rotate(axis=Z, angle=90deg) in RelativeCS1
  Rotor.rotate(axis=Z, angle=90deg) in RelativeCS1
  Rotor.rotate(axis=Z, angle=135deg) in RelativeCS1
  Rotor.rotate(axis=Z, angle=45deg) in RelativeCS1
  Rotor.rotate(axis=Z, angle=90deg) in RelativeCS1
  Rotor.rotate(axis=Z, angle=90deg) in RelativeCS1
  Rotor.rotate(axis=Z, angle=-45deg) in RelativeCS1
  Rotor.rotate(axis=Z, angle=-45deg) in RelativeCS1
  Rotor.rotate(axis=Z, angle=90deg) in RelativeCS1
  Rotor.rotate(axis=Z, angle=-45deg) in RelativeCS1
  Rotor.rotate(axis=Z, angle=-45deg) in RelativeCS1
  Rotor.rotate(axis=Z, angle=90deg) in RelativeCS1
  Rotor.rotate(axis=Z, angle=angle) in RelativeCS1
  Rotor.rotate(axis=Z, angle=-45deg) in RelativeCS1
  Rotor.rotate(axis=Z, angle=45deg) in RelativeCS1
  Rotor.rotate(axis=Z, angle=-45deg) in RelativeCS1
  Rotor.rotate(axis=Z, angle=45deg) in RelativeCS1
  Rotor.rotate(axis=Z, angle=-45deg) in RelativeCS1
  Rotor.rotate(axis=Z, angle=-45deg) in RelativeCS1
  Rotor.rotate(axis=Z, angle=45deg) in RelativeCS1
  Rotor.rotate(axis=Z, angle=45deg) in RelativeCS1
  Rotor.rotate(axis=Z, angle=-45deg) in RelativeCS1
  Rotor.rotate(axis=Z, angle=-45deg) in RelativeCS1
  Rotor.rotate(axis=Z, angle=90deg) in RelativeCS1
  Rotor.rotate(axis=Z, angle=-40deg) in RelativeCS1
  Rotor.rotate(axis=Z, angle=80deg) in RelativeCS1
  Rotor.rotate(axis=Z, angle=-40deg) in RelativeCS1
  Rotor.rotate(axis=Z, angle=-45deg) in RelativeCS1
  Rotor.rotate(axis=Z, angle=-45deg) in RelativeCS1
  Rotor.rotate(axis=Z, angle=90deg) in RelativeCS1
  Strator [M19_24G - nonlineer] = imported_body()
  [Rotor, Strator].sweep_along_vector((0mm, 0mm, 25mm))
  Region [vacuum] = region(percentage_offset=100 on all sides)
  Coil1 [copper] = box(corner=(-10mm, 50mm, 0mm), size=(35mm, -30mm, 35mm))
  Coil1.move(0mm, 0mm, -5mm)
  Strator_1 = Strator.copy()
  Coil1.subtract(Strator_1)
  Rectangle4 = rectangle(corner=(-7.5mm, 30mm, 5mm), y_size=30mm, z_size=-5mm)
  Rectangle4.move(0mm, -5mm, -10mm)
  Rectangle4.move(16.25mm, -5mm, -30mm)
  Rectangle4.move(0mm, 0mm, 35mm)
  Rotor.rotate(axis=Z, angle=-45deg) in RelativeCS1
  Rotor.rotate(axis=Z, angle=45deg) in RelativeCS1
  Rotor.rotate(axis=Z, angle=-45deg) in RelativeCS1
  Rotor.rotate(axis=Z, angle=-45deg) in RelativeCS1
  Rotor.rotate(axis=Z, angle=90deg) in RelativeCS1
  Rotor.rotate(axis=Z, angle=-45deg) in RelativeCS1
  Rotor.rotate(axis=Z, angle=-45deg) in RelativeCS1
  Rotor.rotate(axis=Z, angle=90deg) in RelativeCS1
boundaries and excitations:
  Insulating1: Insulating Objects=Region
  CoilTerminal1: Coil Terminal Objects=Rectangle4 Conductor_number=300 Winding=Winding1 Point_out_of_terminal=false
  Winding1: Winding Group Type=Current IsSolid=false Current=2.5A ParallelBranchesNum=1
parameters:
  Matrix1: Matrix Winding1: NumberOfTurns=1
  Torque1: Torque Is_Virtual=true Coordinate_System=RelativeCS1 Axis=Z Is_Positive=true Objects=Rotor
mesh:
  initial mesh: GlobalCurvilinear{Apply}
setups:
  Setup1: Magnetostatic MaximumPasses=10 MinimumPasses=2 MinimumConvergedPasses=1 PercentRefinement=30 PercentError=1 NonLinearResidual=0.001
optimetrics:
  ParametricSetup1: Parametric Sim._Setups=[Setup1]
    sweep angle: LIN 0deg 360deg 10deg
output variables:
  Torque1 = Torque1.Torque
field plots:
  B_Vector1: B in Strator, Rotor on Setup1 : LastAdaptive
reports:
  Torque Plot1: Torque1.Torque vs angle on Setup1 : LastAdaptive
  L Plot1: Matrix1.L(Winding1,Winding1) vs angle on Setup1 : LastAdaptive

design Maxwell2DDesign1 (Maxwell 2D, Magnetostatic, XY geometry, model units mm)
options: ModelDepth=0.025meter
variables:
  angle = 0deg
  control_signal = if((angle > 90deg && angle < 180deg) || (angle > 270deg && angle < 360deg), 1, 0)
geometry:
  point Point1 = (7.5mm, -0.5mm, 0mm)
  Circle1 = circle(normal=Z, centre=(0mm, 0mm, 0mm), radius=10mm)
  Rotor [M19_24G - nonlineer] = circle(normal=Z, centre=(0mm, 0mm, 0mm), radius=12mm)
  Rectangle2 = rectangle(corner=(7.507mm, 9.367mm, 0mm), x_size=6.093mm, y_size=-18.767mm)
  Rotor.subtract(Rectangle2)
  Rectangle3 = rectangle(corner=(-7.5mm, 9.367mm, 0mm), x_size=-5mm, y_size=-50mm)
  Rotor.subtract(Rectangle3)
  Rotor.unite(Circle1)
  Rotor.move(1.9992392mm, 0mm, 0mm)
  Rotor.move(0.5mm, 0mm, 0mm)
  Rotor.move(22.5mm, -15mm, 0mm)
  Rotor.move(-24mm, 14mm, 0mm)
  Rotor.move(-23mm, 0mm, 0mm)
  Rotor.move(22mm, 1mm, 0mm)
  Rotor.move(0mm, -5mm, 0mm)
  Rotor.move(25mm, 5mm, 0mm)
  Rotor.move(-3mm, 0mm, 0mm)
  Rotor.move(30mm, -2mm, 0mm)
  Rotor.move(0.5mm, 0mm, 0mm)
  Rotor.move(0mm, 4mm, 0mm)
  Rotor.move(0mm, -2mm, 0mm)
  Rotor.move(0mm, 2mm, 0mm)
  Rotor.move(0mm, 35mm, 0mm)
  coil1 [copper] = rectangle(corner=(0mm, 0mm, 0mm), x_size=10mm, y_size=30mm)
  coil1.move(-20mm, 20mm, 0mm)
  coil1.move(36mm, 1mm, 0mm)
  coil1.move(8mm, -1mm, 0mm)
  coil1.move(-44mm, 0mm, 0mm)
  coil1.move(1mm, -1mm, 0mm)
  coil1.move(1mm, 1mm, 0mm)
  coil2 [copper] = rectangle(corner=(0mm, 0mm, 0mm), x_size=10mm, y_size=30mm)
  coil2.move(-20mm, 20mm, 0mm)
  coil2.move(36mm, 1mm, 0mm)
  coil2.move(8mm, -1mm, 0mm)
  coil2.move(-44mm, 0mm, 0mm)
  coil2.move(1mm, -1mm, 0mm)
  coil2.move(1mm, 1mm, 0mm)
  coil2.move(43mm, 0mm, 0mm)
  coil1.move(8mm, 1mm, 0mm)
  coil1.move(0mm, 1mm, 0mm)
  coil1.move(0mm, -2mm, 0mm)
  coil2.move(-10mm, 0mm, 0mm)
  Region [vacuum] = region(percentage_offset: +X=10, -X=10, +Y=10, -Y=10, +Z=0, -Z=0)
  coordinate_system RelativeCS1 = origin=(52.5mm, 37mm, 0mm) x=(1mm, 0mm, 0mm) y=(0mm, 1mm, 0mm)
  Rotor.rotate(axis=Z, angle=135deg) in RelativeCS1
  Rotor.rotate(axis=Z, angle=45deg) in RelativeCS1
  Rotor.rotate(axis=Z, angle=90deg) in RelativeCS1
  Rotor.rotate(axis=Z, angle=90deg) in RelativeCS1
  Rotor.rotate(axis=Z, angle=135deg) in RelativeCS1
  Rotor.rotate(axis=Z, angle=45deg) in RelativeCS1
  Rotor.rotate(axis=Z, angle=90deg) in RelativeCS1
  Rotor.rotate(axis=Z, angle=90deg) in RelativeCS1
  Strator [M19_24G - nonlineer] = imported_body()
  Rotor.rotate(axis=Z, angle=-45deg) in RelativeCS1
  Rotor.rotate(axis=Z, angle=-45deg) in RelativeCS1
  Rotor.rotate(axis=Z, angle=90deg) in RelativeCS1
  Rotor.rotate(axis=Z, angle=-45deg) in RelativeCS1
  Rotor.rotate(axis=Z, angle=-45deg) in RelativeCS1
  Rotor.rotate(axis=Z, angle=90deg) in RelativeCS1
  Rotor.rotate(axis=Z, angle=angle) in RelativeCS1
  Rotor.rotate(axis=Z, angle=-45deg) in RelativeCS1
  Rotor.rotate(axis=Z, angle=45deg) in RelativeCS1
  Rotor.rotate(axis=Z, angle=-45deg) in RelativeCS1
  Rotor.rotate(axis=Z, angle=45deg) in RelativeCS1
  Rotor.rotate(axis=Z, angle=-45deg) in RelativeCS1
  Rotor.rotate(axis=Z, angle=-45deg) in RelativeCS1
  Rotor.rotate(axis=Z, angle=45deg) in RelativeCS1
  Rotor.rotate(axis=Z, angle=45deg) in RelativeCS1
  Rotor.rotate(axis=Z, angle=-45deg) in RelativeCS1
  Rotor.rotate(axis=Z, angle=-45deg) in RelativeCS1
  Rotor.rotate(axis=Z, angle=90deg) in RelativeCS1
  Rotor.rotate(axis=Z, angle=-40deg) in RelativeCS1
  Rotor.rotate(axis=Z, angle=80deg) in RelativeCS1
  Rotor.rotate(axis=Z, angle=-40deg) in RelativeCS1
  Rotor.rotate(axis=Z, angle=-45deg) in RelativeCS1
  rotor_airgap [vacuum] = circle(normal=Z, centre=(0mm, 0mm, 0mm), radius=12.5mm) in RelativeCS1
  Rotor_1 = Rotor.copy()
  rotor_airgap.subtract(Rotor_1)
  Strator_1 = Strator.copy()
  rotor_airgap.subtract(Strator_1)
  [Rotor, rotor_airgap].rotate(axis=Z, angle=-45deg) in RelativeCS1
  [Rotor, rotor_airgap].rotate(axis=Z, angle=90deg) in RelativeCS1
boundaries and excitations:
  VectorPotential1: Vector Potential Edges=Region.edge(all 4) Value=0
  coil1: Coil Objects=coil1 Conductor_number=300 Winding=Winding1 PolarityType=Positive
  coil2: Coil Objects=coil2 Conductor_number=300 Winding=Winding1 PolarityType=Negative
  Winding1: Winding Group Type=Current IsSolid=false Current=2.5A ParallelBranchesNum=1
parameters:
  Matrix1: Matrix Winding1: NumberOfTurns=1
  Torque1: Torque Coordinate_System=RelativeCS1 Is_Positive=true Objects=Rotor
mesh:
  Length1: LengthBased RefineInside Objects=coil1 MaxLength=1mm
  Length2: LengthBased RefineInside Objects=coil2 MaxLength=1mm
  Length3: LengthBased RefineInside Objects=Rotor MaxLength=0.5mm
  Length4: LengthBased RefineInside Objects=Strator MaxLength=2mm
setups:
  Setup1: Magnetostatic MaximumPasses=20 MinimumPasses=2 MinimumConvergedPasses=1 PercentRefinement=30 PercentError=0.5 NonLinearResidual=0.0001
optimetrics:
  ParametricSetup1: Parametric Sim._Setups=[Setup1]
    sweep angle: LIN 0deg 360deg 10deg
output variables:
  Torque1 = Torque1.Torque
  Inductance1 = Matrix1.L(Winding1,Winding1)
field plots:
  Mag_B1, B_Vector1: B over Strator, Rotor, rotor_airgap on Setup1 : LastAdaptive
reports:
  Output Variables Plot1: Torque1 vs angle on Setup1 : LastAdaptive
  Output Variables Plot2: Inductance1 vs angle on Setup1 : LastAdaptive
