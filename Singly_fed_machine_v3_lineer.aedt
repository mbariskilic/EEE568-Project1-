# Ansys Electronics Desktop project, version 2025.2
project variables:
  $R1 = 10mm
  $R2 = 12mm
  $Rs = 12.5mm
  $Wp = 15mm
  $y1 = sqrt($R1*$R1 - ($Wp/2)*($Wp/2))
  $y2 = sqrt($R2*$R2 - ($Wp/2)*($Wp/2))
materials:
  vacuum: permittivity=1
  M19_24G: permeability=2500 conductivity=1960000 core_loss_type="Electrical Steel" core_loss_kh=164.2 core_loss_kc=1.3 core_loss_ke=1.72 mass_density=7650
  copper: permeability=0.999991 conductivity=58000000

design Maxwell2DDesign1 (Maxwell 2D, Magnetostatic, XY geometry, model units mm)
options: ModelDepth=0.025meter
variables:
  angle = 0deg
geometry:
  point Point1 = (7.5mm, -0.5mm, 0mm)
  Circle1 = circle(normal=Z, centre=(0mm, 0mm, 0mm), radius=10mm)
  Rotor [M19_24G] = circle(normal=Z, centre=(0mm, 0mm, 0mm), radius=12mm)
  Rectangle2 = rectangle(corner=(7.507mm, 9.367mm, 0mm), x_size=6.093mm, y_size=-18.767mm)
  Rotor.subtract(Rectangle2)
  Rectangle3 = rectangle(corner=(-7.5mm, 9.367mm, 0mm), x_size=-5mm, y_size=-50mm)
  Rotor.subtract(Rectangle3)
  Rotor.unite(Circle1)
  Rotor.move(1.9992392mm, 0mm, 0mm)
  Rotor.move(0.5mm, 0mm, 0mm)
  Rotor.move(22.5mm, -15mm, 0mm)
  Rotor.move(-24mm, 14mm, 0mm)
  Rotor.move(-23mm, 0mm, 0mm)
  Rotor.move(22mm, 1mm, 0mm)
  Rotor.move(0mm, -5mm, 0mm)
  Rotor.move(25mm, 5mm, 0mm)
  Rotor.move(-3mm, 0mm, 0mm)
  Airgap_1 [vacuum] = circle(normal=Z, centre=(22mm, 0mm, 0mm), radius=12.5mm)
  [Rotor, Airgap_1].move(30mm, -2mm, 0mm)
  [Rotor, Airgap_1].move(0.5mm, 0mm, 0mm)
  [Rotor, Airgap_1].move(0mm, 4mm, 0mm)
  [Rotor, Airgap_1].move(0mm, -2mm, 0mm)
  [Rotor, Airgap_1].move(0mm, 2mm, 0mm)
  [Rotor, Airgap_1].move(0mm, 35mm, 0mm)
  coil1 [copper] = rectangle(corner=(0mm, 0mm, 0mm), x_size=10mm, y_size=30mm)
  coil1.move(-20mm, 20mm, 0mm)
  coil1.move(36mm, 1mm, 0mm)
  coil1.move(8mm, -1mm, 0mm)
  coil1.move(-44mm, 0mm, 0mm)
  coil1.move(1mm, -1mm, 0mm)
  coil1.move(1mm, 1mm, 0mm)
  coil2 [copper] = rectangle(corner=(0mm, 0mm, 0mm), x_size=10mm, y_size=30mm)
  coil2.move(-20mm, 20mm, 0mm)
  coil2.move(36mm, 1mm, 0mm)
  coil2.move(8mm, -1mm, 0mm)
  coil2.move(-44mm, 0mm, 0mm)
  coil2.move(1mm, -1mm, 0mm)
  coil2.move(1mm, 1mm, 0mm)
  coil2.move(43mm, 0mm, 0mm)
  coil1.move(8mm, 1mm, 0mm)
  coil1.move(0mm, 1mm, 0mm)
  coil1.move(0mm, -2mm, 0mm)
  coil2.move(-10mm, 0mm, 0mm)
  Region [vacuum] = region(percentage_offset: +X=10, -X=10, +Y=10, -Y=10, +Z=0, -Z=0)
  coil1_1 = coil1.copy()
  coil1_1.delete()
  coil2_1 = coil2.copy()
  coil2_1.delete()
  Airgap_1_1 = Airgap_1.copy()
  Airgap_1_1.delete()
  Rotor_1 = Rotor.copy()
  Rotor_1.delete()
  Rotor_2 = Rotor.copy()
  Airgap_1.subtract(Rotor_2)
  coordinate_system RelativeCS1 = origin=(52.5mm, 37mm, 0mm) x=(1mm, 0mm, 0mm) y=(0mm, 1mm, 0mm)
  [Rotor, Airgap_1].rotate(axis=Z, angle=135deg) in RelativeCS1
  [Rotor, Airgap_1].rotate(axis=Z, angle=45deg) in RelativeCS1
  Rotor.rotate(axis=Z, angle=90deg) in RelativeCS1
  Airgap_1.rotate(axis=Z, angle=90deg) in RelativeCS1
  [Rotor, Airgap_1].rotate(axis=Z, angle=90deg) in RelativeCS1
  [Rotor, Airgap_1].rotate(axis=Z, angle=135deg) in RelativeCS1
  [Rotor, Airgap_1].rotate(axis=Z, angle=45deg) in RelativeCS1
  Rotor.rotate(axis=Z, angle=90deg) in RelativeCS1
  Airgap_1.rotate(axis=Z, angle=90deg) in RelativeCS1
  [Rotor, Airgap_1].rotate(axis=Z, angle=90deg) in RelativeCS1
  Strator [M19_24G] = imported_body()
  Rotor.rotate(axis=Z, angle=-45deg) in RelativeCS1
  Airgap_1.rotate(axis=Z, angle=-45deg) in RelativeCS1
  [Rotor, Airgap_1].rotate(axis=Z, angle=-45deg) in RelativeCS1
  [Rotor, Airgap_1].rotate(axis=Z, angle=90deg) in RelativeCS1
  Rotor.rotate(axis=Z, angle=-45deg) in RelativeCS1
  Airgap_1.rotate(axis=Z, angle=-45deg) in RelativeCS1
  [Rotor, Airgap_1].rotate(axis=Z, angle=-45deg) in RelativeCS1
  [Rotor, Airgap_1].rotate(axis=Z, angle=90deg) in RelativeCS1
  [Rotor, Airgap_1].rotate(axis=Z, angle=angle) in RelativeCS1
  [Rotor, Airgap_1].rotate(axis=Z, angle=-45deg) in RelativeCS1
  [Rotor, Airgap_1].rotate(axis=Z, angle=45deg) in RelativeCS1
  [Rotor, Airgap_1].rotate(axis=Z, angle=-45deg) in RelativeCS1
  [Rotor, Airgap_1].rotate(axis=Z, angle=45deg) in RelativeCS1
boundaries and excitations:
  VectorPotential1: Vector Potential Edges=Region.edge(all 4) Value=0
  coil1: Coil Objects=coil1 Conductor_number=300 Winding=Winding1 PolarityType=Positive
  coil2: Coil Objects=coil2 Conductor_number=300 Winding=Winding1 PolarityType=Negative
  Winding1: Winding Group Type=Current IsSolid=false Current=2.5A ParallelBranchesNum=1
parameters:
  Matrix1: Matrix Winding1: NumberOfTurns=1
  Torque1: Torque Coordinate_System=Global Is_Positive=true Objects=Rotor
mesh:
  Length1: LengthBased RefineInside Objects=coil1 MaxLength=1mm
  Length2: LengthBased RefineInside Objects=coil2 MaxLength=1mm
  Length3: LengthBased RefineInside Objects=Rotor MaxLength=0.5mm
setups:
  Setup1: Magnetostatic MaximumPasses=20 MinimumPasses=2 MinimumConvergedPasses=1 PercentRefinement=30 PercentError=0.5 ConstantDelta=0s NonLinearResidual=0.0001
optimetrics:
  ParametricSetup1: Parametric disabled Sim._Setups=[Setup1]
    sweep angle: LIN 0deg 360deg 10deg
output variables:
  Torque1 = Torque1.Torque
  Inductance1 = Matrix1.L(Winding1,Winding1)
reports:
  Output Variables Plot1: Torque1 vs angle on Setup1 : LastAdaptive
  Output Variables Plot2: Inductance1 vs angle on Setup1 : LastAdaptive
